* tran_pw: closed-loop inverting amplifier, 0.477394 Vpk 10 kHz
.include /home/user/ecen326-agent-opt/models/cd4007.lib
.include /home/user/ecen326-agent-opt/models/power_fets.lib
.options reltol=1e-4 abstol=1e-10 vntol=1e-7 gmin=1e-12 itl1=500 itl2=500 itl4=200
* ---- amplifier core ----
VCC1 vcc1 0 DC 5
VCC2 vcc2 0 DC 5
* stage 1: CD4007 differential pair, PMOS mirror load (bodies: P to VCC1, N to ground)
M1 vg1 vg1 vcc1 vcc1 CD4007P W=360u L=10u
M2 vo1 vg1 vcc1 vcc1 CD4007P W=360u L=10u
M3 vg1 inn vt 0 CD4007N W=170u L=10u
M6 vo1 inp vt 0 CD4007N W=170u L=10u
VTAIL vt vt4 DC 0
M4 vt4 vg4 0 0 CD4007N W=170u L=10u
R1 vcc1 vg4 5000
R2 vg4 0 10000
CC vo1 vodc 1e-11
* buffer: 2N7000 source follower, class-AB gate bias network
VSQ3 vcc1 dq3 DC 0
XQ3 dq3 vo1 vq1 2N7000
RK vq1 0 47
RS vq2 vq1 47
RUP vcc1 vq2 150
* output stage: 1 x IRF9520 (high side) + 1 x IRLZ44N (low side)
XQ1_1 dp1 vq1 vcc2 IRF9520
VSP1 dp1 vodc DC 0
XQ2_1 vodc vq2 sn1 IRLZ44N
VSN1 sn1 0 DC 0
C1 vodc vo 0.001
RL vo 0 8
RB1 vcc2 inp 100000
RB2 inp 0 100000
CB inp 0 1e-05
VSIG src 0 DC 0 SIN(0 0.477394 10000)
CIN src nin 1e-07
RIN nin inn 220000
RF vodc inn 950000
.control
set filetype=ascii
set wr_singlescale
set wr_vecnames
tran 2.5e-07 0.002 0 2.5e-07
linearize
wrdata /home/user/ecen326-agent-opt/baseline/sim/tran_pw.txt v(vo) v(vodc) v(src) v(vcc1) v(vcc2) v(vq1) v(vo1) i(VCC1) i(VCC2) i(VTAIL) i(VSQ3) i(VSP1) i(VSN1)
fourier 10000 v(vo) > /home/user/ecen326-agent-opt/baseline/sim/tran_pw_fourier.txt
.endc
.end
